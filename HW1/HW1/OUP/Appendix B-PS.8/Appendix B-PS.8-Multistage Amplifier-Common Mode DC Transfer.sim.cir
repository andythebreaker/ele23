** Profile: "Multistage Amplifier-Common Mode DC Transfer"  [ C:\Documents and Settings\Adel Sedra\My Documents\SEDRA WORK\SEDRA-PSPICE-CD\CHAPTER 7\chapter 7-multistage amplifier-common mode dc transfer.sim ]

** Creating circuit file "chapter 7-multistage amplifier-common mode dc transfer.sim.cir"
** WARNING: THIS AUTOMATICALLY GENERATED FILE MAY BE OVERWRITTEN BY SUBSEQUENT SIMULATIONS

*Libraries:
* Local Libraries :
.LIB "..\sedra_lib.lib"
* From [PSPICE NETLIST] section of e:\cadence\tools\PSpice\PSpice.ini file:
.lib "nom.lib"

*Analysis directives:
.DC LIN V_VCM -15 15 1m
.PROBE V(alias(*)) I(alias(*)) W(alias(*)) D(alias(*)) NOISE(alias(*))
.INC ".\chapter 7-Multistage Amplifier.net"

.END
